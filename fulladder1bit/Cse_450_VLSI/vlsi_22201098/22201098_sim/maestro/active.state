ADE simulation setup
Test vlsi_22201098_22201098_sim_1: vlsi_22201098/22201098_sim/schematic, simulator spectre
  Models: /home/cadence/tech/gpdk045_v_6_0/gpdk045/../models/spectre/gpdk045.scs[mc]
  Temperature: 27
  Analysis tran: stop=100n
  Signals: /vout, /v1 as v1, /v2 as v2
