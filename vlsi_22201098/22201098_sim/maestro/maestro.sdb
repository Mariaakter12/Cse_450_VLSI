ADE simulation setup
Run mode: Single Run, Sweeps and Corners
Tests:
  vlsi_22201098_22201098_sim_1: vlsi_22201098/22201098_sim/schematic, simulator spectre
